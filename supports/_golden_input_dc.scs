// SPICECiM-X v3 DC-mode testbench (paramset + sweep, per Spectre Reference
// Manual page 509 "Parameter Set - Block of Data (paramset)" and page 406
// "Sweep Analysis (sweep)"). One elaboration, M Newton solves, one combined
// swept-DC PSF output.
// Generated by spicecimx.sim.templates.render_testbench_dc.
// Spectre is invoked with cwd = job_cwd, so all relative includes resolve
// inside the per-job working directory.
simulator lang=spectre
global 0
include "<transistor_mod>" section=<pcorner>
include "device_model.scs"
include "seed_netlist.scs"

<input_source>

Vvd (VDD 0) vsource dc=<vdd> type=dc
Vvs (VSS 0) vsource dc=<vss> type=dc
Vae (AE  0) vsource dc=<vdd> type=dc
Vpgmen (PGMEN 0) vsource dc=<vss> type=dc
Vddp   (VDDP  0) vsource dc=<vdd> type=dc

simulatorOptions options psfversion="1.4.0" reltol=1e-3 vabstol=1e-6 \
    iabstol=1e-12 temp=<temp> tnom=27 scalem=1.0 scale=1.0 gmin=1e-12 \
    rforce=1 maxnotes=5 maxwarns=5 digits=5 cols=80 pivrel=1e-3 \
    checklimitdest=psf

<altergroups>

save <csnames>
saveOptions options save=selected pwr=total currents=selected
