simulator lang=spectre
global 0
include "<transistor_mod>" section=<pcorner>
include "device_model.scs"
include "seed_netlist.scs"

<input_source>

Vvd (VDD 0) vsource dc=<vdd> type=dc
Vvs (VSS 0) vsource dc=<vss> type=dc
Vae (AE 0) vsource dc=<vdd> type=dc
Vpgmen (PGMEN 0) vsource dc=<vss> type=dc
Vddp   (VDDP  0) vsource dc=<vdd> type=dc

simulatorOptions options psfversion="1.4.0" reltol=1e-3 vabstol=1e-6 \
    iabstol=1e-12 temp=<temp> tnom=27 scalem=1.0 scale=1.0 gmin=1e-12 rforce=1 \
    maxnotes=5 maxwarns=5 digits=5 cols=80 pivrel=1e-3 \
    sensfile="../psf/sens.output" checklimitdest=psf
tran tran stop=<sim_time> errpreset=conservative write="spectre.ic" \
    writefinal="spectre.fc" annotate=status maxiters=5

finalTimeOP info what=oppoint where=rawfile
modelParameter info what=models where=rawfile
element info what=inst where=rawfile
outputParameter info what=output where=rawfile
designParamVals info what=parameters where=rawfile
primitives info what=primitives where=rawfile
subckts info what=subckts where=rawfile
save <csnames>
saveOptions options save=selected pwr=total currents=selected
